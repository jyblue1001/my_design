`include "constants.vams"
`include "disciplines.vams"

module VCO  (vin,vout);
    input vin; voltage vin;
    output vout; voltage vout;

/************* Internal Parameter ***********/
    real phase;
    real phase_ideal;
    real fc;
    real fout;
    real f_ideal;
    real dT;
    real jitter = 10e-12;  // adjusted jitter
    real gain;
    real vout_r;
    real vout_amp;
    real ttol;
    real vtol;
    integer min_pts_update = 64;
    integer seed;

/************* Behavioral Block ***********/
    analog begin
        // Initialize values at the start of the simulation
        @(initial_step) begin
            fc = 2.4e9;
            gain = 200e6;
            seed = 100;
            vout_amp = 1;
            ttol = 1e-9 / (2e9);
            vtol = 1e-15;
        end

        // Calculate ideal frequency based on input voltage
        f_ideal = fc + gain * V(vin);

        // Bound the time step to avoid simulation inaccuracies
        $bound_step(1 / (min_pts_update * fout));

        // Calculate phase for both real and ideal frequency
        phase = 2 * `M_PI * idtmod(fout, 0, 1, -0.5);
        phase_ideal = 2 * `M_PI * idtmod(f_ideal, 0, 1, -0.5);

        // Instead of using events, monitor phase continuously
        if (phase >= -`M_PI/2 && phase <= `M_PI/2) begin
            vout_r = 1;
        end else begin
            vout_r = 0;
        end

        // Simplified jitter model: Use jitter value without random distribution
        dT = 1.414 * jitter;
        fout = f_ideal * (1 + dT * f_ideal);

        // Set output voltage based on vout_r (real phase)
        V(vout) <+ vout_r ? vout_amp : 0;
    end
endmodule
